////////////////////////////////////////////////
// VLSI bipolar_aSiCCuTiN  RRAM pristine state with Hard Switching / Soft Switching model
////////////////////////////////////////////////

////////////////////////////////////////////////
// v1.1, 17/05/2016
////////////////////////////////////////////////
// Author: Fernando García-Redondo
// fgarcia@die.upm.es, fernandeando.com
// Technical University of Madrid
//
// https://github.com/fgr1986/vlsi_memristor_compact_model
// http://vlsi.die.upm.es/memristor_spice_model
////////////////////////////////////////////////

////////////////////////////////////////////////
// License:
// Copyright of the model is maintained by the developers,
// and the model is distributed under a Dual-Licence mode.
// 1) GPL License apply for academic purposes.
// If you use this model in your work, you are requested to cite [1] in the reference.
// GitHub Repository and Downloads
// 2) Commercial license for other purposes not meeting GPL license: Contact *fgarcia@die.upm.es*
// Full License: LICENSE.txt
//
// [1] SPICE Compact Modeling of Bipolar/Unipolar Memristor Switching Governed by Electrical Thresholds
// Fernando García-Redondo et. al.
// IEEE Transactions on Circuits and Systems--I: Regular Papers
// 2016, DOI: 10.1109/TCSI.2016.2564703
////////////////////////////////////////////////

////////////////////////////////////////////////
// 1) Nominal memristor
// 2) Pristine state
// 3) Asymetric conductance
// 4) Hard Switching / Soft Switching
////////////////////////////////////////////////

simulator lang=spectre

// aux variability functions
include "variability.scs"

// normalize function
// used by soft-switching method
real normalize(real a, real p) {
	return min(1, max( 0, sgn(a)*pow(a, p) ));
}

///////////////////////
// RRAM subcircuit
///////////////////////
subckt memristor (Plus Minus)

	///////////////////////
  // parameters
	///////////////////////
  parameters
    // constants
    // [a.u.]       [J/K]       [C]	         [F/m]
    + pi=3.1415926  Kb=1.38e-23 q=1.6e-19  eps_0=8.85e-12;
    // conductance parameters
    // [m^2]      [m]    [1/V]     [1/V]    [A/(m^2 K^2)] [eV]
    + area=6.4e-9 d=4e-8 scl_p=5  scl_n=7 AA_p=2.4e6    AA_n=1e6      Ub=0.9
    // [a.u.] [ohm]   [K]
    + eps_r=8 Ron=300 T0=300 k_temp=1
    // [A]  [ohms]      [ohms]
    + cI=1e-4 r_on_p=6.1k r_on_n=8.5k
    // [F/m]
    + eps_i=eps_r*eps_0

    // energy threshold parameters
    + p_th_set=3e-12 p_th_reset=-0.8e-8 p_th_pristine=20e-14
    // windowing: soft switching
    // + p=4
    // voltage dependent variabiligy: windowing
		+ p_rand_i=4
    // internal params
    + v_off=1e-7 v_on=2e-7 v_pristine=0

	///////////////////////
  // energy computation
	///////////////////////
	ic p_sum_pow=0
  E_pos_power ( p_sum_pow 0 ) bsource v= idt( v(Plus, Minus)>0 && v(p_sum_pow)<v(set_th) ? v(Plus, Minus)*abs(i(G_cond)) : 0, 0 )
	ic n_sum_pow=0
	E_neg_power ( n_sum_pow 0 ) bsource v= idt( v(Plus, Minus)<0 && v(n_sum_pow)>v(reset_th) ? v(Plus, Minus)*abs(i(G_cond)) : 0, 0 )

	////////////////////////////
	// thresholds computation
	////////////////////////////
	ic set_th=p_th_set
	ic reset_th=p_th_reset
	// no pristine
	// E_set_th   ( set_th   0 ) bsource v= ( floor( v(n_sum_pow)/p_th_reset ) + 1 )*p_th_set
	// pristine
	E_set_th   ( set_th   0 ) bsource v= ( floor( v(n_sum_pow)/p_th_reset ) + 1 )*p_th_set + p_th_pristine
	E_reset_th ( reset_th 0 ) bsource v= floor( v(p_sum_pow)/p_th_set )*( p_th_reset )

  ////////////////////////////
  // state computation
  // E_state=0 -> off state; E_state=1 -> on  state
	////////////////////////////
	// no pristine
  // ic state=v_off
  // E_state ( state 0 ) bsource  v=  v(state)==v_off ? (v(p_sum_pow)>v(set_th) ? v_on : v_off ) : ( v(n_sum_pow)<v(reset_th) ? v_off : v_on )
	// pristine
	ic state=v_pristine
  E_state ( state 0 ) bsource  v= v(state)==v_pristine ? (v(p_sum_pow)>p_th_pristine ? v_on : v_pristine ) : v(state)==v_off ? (v(p_sum_pow)>v(set_th) ? v_on : v_off ) : ( v(n_sum_pow)<v(reset_th) ? v_off : v_on )

	////////////////////////////
	// conduction computation
	////////////////////////////
  // on modeling including complain current
  // E_on ( on 0 ) bsource v=max( -cI*r_on, min( cI*r_on, v(Plus, Minus) ))
  E_on ( on 0 ) bsource v=v(Plus, Minus)
  Ron_p  ( on 0 ) bsource r=r_on_p
  Ron_n  ( on 0 ) bsource r=r_on_n

	// pristine modeling
	G_pristine ( 0 pristine ) bsource i= 1e-2*sgn(v(Plus, Minus)) * area*AA_p*k_temp*(T0**2)*exp(-q * Ub / (Kb * T0) ) * exp( sqrt(abs(v(Plus, Minus)) ) * (scl_p + q / (Kb * T0) * ( sqrt(q / (d * 4 * pi * eps_i)))) )

  // off modeling
	// Simetric conduction
  // G_off ( 0 off ) bsource i= sgn(v(Plus, Minus))*area*AA*k_temp*(T0**2)*exp(-q * Ub / (Kb * T0) ) * exp( sqrt(abs(v(Plus, Minus)) ) * (scl_on + q / (Kb * T0) * ( sqrt(q / (d * 4 * pi * eps_i)))) )
	// Asimetric conduction
  G_off_p ( 0 off_p ) bsource i=  area*AA_p*k_temp*(T0**2)*exp(-q * Ub / (Kb * T0) ) * exp( sqrt(abs(v(Plus, Minus)) ) * (scl_p + q / (Kb * T0) * ( sqrt(q / (d * 4 * pi * eps_i)))) )
  G_off_n ( 0 off_n ) bsource i= -area*AA_n*k_temp*(T0**2)*exp(-q * Ub / (Kb * T0) ) * exp( sqrt(abs(v(Plus, Minus)) ) * (scl_n + q / (Kb * T0) * ( sqrt(q / (d * 4 * pi * eps_i)))) )

  // soft switch
  // E_cond ( b 0 ) bsource v= v(state)==v_off ? normalize( v(p_sum_pow)/p_th_set, p ) : 1 - normalize( v(n_sum_pow)/p_th_reset, p )
  // G_cond ( Plus Minus ) bsource i=max( -cI, min(cI, (1-v(b))*i(Roff) + v(b)*i(Ron) ))
  //  hard switch Asimetric conduction no pristine
  // G_cond ( Plus Minus ) bsource i=max( -cI, min(cI, v(state)==v_off ? ( v(Plus, Minus)>0 ? i(G_off_p) : i(G_off_n) ) : ( v(Plus, Minus)>0 ? i(Ron_p) : i(Ron_n) ) ))
	// hard switch Asimetric conduction pristine
	G_cond ( Plus Minus ) bsource i=max( -cI, min(cI, v(state)==v_pristine ? i(G_pristine) : v(state)==v_off ? ( v(Plus, Minus)>0 ? i(G_off_p) : i(G_off_n) ) : ( v(Plus, Minus)>0 ? i(Ron_p) : i(Ron_n) ) ))

	////////////////////////////
	// cycles computation
	////////////////////////////
  E_cycle  ( cycle  0 ) bsource v=floor( v(n_sum_pow)/p_th_reset )
  E_sEvent ( sEvent 0 ) bsource v=floor( v(n_sum_pow)/p_th_reset ) + floor( v(p_sum_pow)/p_th_set )

ends memristor
