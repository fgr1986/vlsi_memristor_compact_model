////////////////////////////////////////////////
// VLSI bipolar_aSiCCuTiN  RRAM nominal model
////////////////////////////////////////////////

////////////////////////////////////////////////
// v1.1, 17/05/2016
////////////////////////////////////////////////
// Author: Fernando García-Redondo
// fgarcia@die.upm.es, fernandeando.com
// Technical University of Madrid
//
// https://github.com/fgr1986/vlsi_memristor_compact_model
// http://vlsi.die.upm.es/memristor_spice_model
////////////////////////////////////////////////

////////////////////////////////////////////////
// License:
// Copyright of the model is maintained by the developers,
// and the model is distributed under a Dual-Licence mode.
// 1) GPL License apply for academic purposes.
// If you use this model in your work, you are requested to cite [1] in the reference.
// GitHub Repository and Downloads
// 2) Commercial license for other purposes not meeting GPL license: Contact *fgarcia@die.upm.es*
// Full License: LICENSE.txt
//
// [1] SPICE Compact Modeling of Bipolar/Unipolar Memristor Switching Governed by Electrical Thresholds
// Fernando García-Redondo et. al.
// IEEE Transactions on Circuits and Systems--I: Regular Papers
// 2016, DOI: 10.1109/TCSI.2016.2564703
////////////////////////////////////////////////

////////////////////////////////////////////////
// 1) Nominal memristor
// 2) No Pristine state
// 3) Symetric/Asymetric conductance
// 4) Soft/Hard Switching
////////////////////////////////////////////////

simulator lang=spectre

// normalize function
// used by soft-switching method
real normalize(real a, real p) {
	return min(1, max( 0, sgn(a)*pow(a, p) ));
}

///////////////////////
// RRAM subcircuit
///////////////////////
subckt memristor (Plus Minus)

	///////////////////////
  // parameters
	///////////////////////
  parameters
    // constants
    // [a.u.]       [J/K]       [C]	         [F/m]
    + pi=3.1415926  Kb=1.38e-23 q=1.6e-19  eps_0=8.85e-12;
    // conductance parameters
    // [m^2]      [m]     [eV]
    + area=6.4e-9 d=4e-8  Ub=0.9
		// degradation [% per one/cycle] [m]
		+ deg_d_ratio=1e-2 min_d=0.1e-10
		// [1/V]    [1/V]  [A/(m^2 K^2)] [A/(m^2 K^2)]
		+ scl_p=5  scl_n=7 AA_p=2.4e6   AA_n=1e6
    // [a.u.] [ohm]   [K]
    + eps_r=8 Ron=300 T0=300 k_temp=1
    // [A]  [ohms]      [ohms]
    + cI=1e-4 r_on_p=6.1k r_on_n=8.5k
    // [F/m]
    + eps_i=eps_r*eps_0

    // energy threshold parameters
    + p_th_set=3e-12 p_th_reset=-0.8e-8
    // windowing: soft switching
    // + p=4
    // voltage dependent variabiligy: windowing
		+ p_rand_i=4
    // internal params
    + v_off=0 v_on=1e-7

	///////////////////////
  // energy computation
	///////////////////////
	ic p_sum_pow=0
  E_pos_power ( p_sum_pow 0 ) bsource v= idt( v(Plus, Minus)>0 && v(p_sum_pow)<v(set_th) ? v(Plus, Minus)*abs(i(G_cond)) : 0, 0 )
	ic n_sum_pow=0
	E_neg_power ( n_sum_pow 0 ) bsource v= idt( v(Plus, Minus)<0 && v(n_sum_pow)>v(reset_th) ? v(Plus, Minus)*abs(i(G_cond)) : 0, 0 )

	////////////////////////////
	// thresholds computation
	////////////////////////////
	ic set_th=p_th_set
	ic reset_th=p_th_reset
	E_set_th   ( set_th   0 ) bsource v= ( floor( v(n_sum_pow)/p_th_reset ) + 1 )*p_th_set
	E_reset_th ( reset_th 0 ) bsource v= floor( v(p_sum_pow)/p_th_set )*( p_th_reset )

  ////////////////////////////
  // state computation
	////////////////////////////
  ic state=v_off
  E_state ( state 0 ) bsource  v=  v(state)==v_off ? (v(p_sum_pow)>v(set_th) ? v_on : v_off ) : ( v(n_sum_pow)<v(reset_th) ? v_off : v_on )

	////////////////////////////
	// conduction computation
	////////////////////////////
  // 1) on modeling including complain current
  // E_on ( on 0 ) bsource v=max( -cI*r_on, min( cI*r_on, v(Plus, Minus) ))
	// 2) on modeling without complain current
  E_on ( on 0 ) bsource v=v(Plus, Minus)
  Ron_p  ( on 0 ) bsource r=r_on_p
  Ron_n  ( on 0 ) bsource r=r_on_n

  // off modeling
	// 			1) Simetric conduction
  // G_off ( 0 off ) bsource i= sgn(v(Plus, Minus))*area*AA*k_temp*(T0**2)*exp(-q * Ub / (Kb * T0) ) * exp( sqrt(abs(v(Plus, Minus)) ) * (scl_on + q / (Kb * T0) * ( sqrt(q / (f_degr_d(v(cycle), d, deg_d_ratio, min_d) * 4 * pi * eps_i)))) )
	//
	// 			2) Asimetric conduction
  G_off_p ( 0 off_p ) bsource i= min( cI, area*AA_p*k_temp*(T0**2)*exp(-q * Ub / (Kb * T0) ) * exp( sqrt(abs(v(Plus, Minus)) ) * (scl_p + q / (Kb * T0) * ( sqrt(q / (f_degr_d(v(cycle), d, deg_d_ratio, min_d) * 4 * pi * eps_i)))) ) )
  G_off_n ( 0 off_n ) bsource i= max( -cI, -area*AA_n*k_temp*(T0**2)*exp(-q * Ub / (Kb * T0) ) * exp( sqrt(abs(v(Plus, Minus)) ) * (scl_n + q / (Kb * T0) * ( sqrt(q / (f_degr_d(v(cycle), d, deg_d_ratio, min_d) * 4 * pi * eps_i)))) ) )

	// Current source selection
	//
  // 		1) soft switch
  // E_cond ( b 0 ) bsource v= v(state)==v_off ? normalize( v(p_sum_pow)/p_th_set, p ) : 1 - normalize( v(n_sum_pow)/p_th_reset, p )
  // G_cond ( Plus Minus ) bsource i=max( -cI, min(cI, (1-v(b))*i(Roff) + v(b)*i(Ron) ))
	//
  // 		2) hard switch Asimetric conduction no pristine
	// test1
	// G_cond ( Plus Minus ) bsource i=max( -cI, min(cI, v(state)==v_off ? ( v(Plus, Minus)>0 ? i(G_off_p) : i(G_off_n) ) : ( v(Plus, Minus)>0 ? max(i(Ron_p), i(G_off_p)) : min(i(Ron_n), i(G_off_n)) )   ))
  G_cond ( Plus Minus ) bsource i=max( -cI, min(cI, v(state)==v_off ? ( v(Plus, Minus)>0 ? min( i(Ron_p), i(G_off_p)) : max( i(Ron_n), i(G_off_n)) ) : ( v(Plus, Minus)>0 ? i(Ron_p) : i(Ron_n) )   ))

	////////////////////////////
	// cycles computation
	////////////////////////////
  E_cycle  ( cycle  0 ) bsource v=floor( v(n_sum_pow)/p_th_reset )
  E_sEvent ( sEvent 0 ) bsource v=floor( v(n_sum_pow)/p_th_reset ) + floor( v(p_sum_pow)/p_th_set )

  E_d  ( my_d  0 ) bsource v=f_degr_d(v(cycle), d, deg_d_ratio, min_d)

	///////////////////////////////////////////
	// Degrades the CF due to incomplete resets
	// The CF is not-properly destroyed
	////////////////////////////////////////////
	real f_degr_d( real cycle, real nominal_d, real deg_d_ratio, real min_d ) {
		return max(min_d, nominal_d*( 1 - cycle*deg_d_ratio ))
		// + cycle < 1 ? 1.100 :
		// + cycle < 1 ? 1;
	}

ends memristor
