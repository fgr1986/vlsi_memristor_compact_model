simulator lang=spectre

// File 0

real cycle_dependent_ron_p_0( real cycle ) {
	return
	+ cycle < 0 ? 0.6788150229339411 :
	+ cycle < 1 ? 1.0482954003521754 :
	+ cycle < 2 ? 1.3506659973443735 :
	+ cycle < 3 ? 1.9009088899466255 :
	+ cycle < 4 ? 1.434604716073114 :
	+ cycle < 5 ? 0.5970969287195453 :
	+ cycle < 6 ? 0.5433912986352618 :
	+ cycle < 7 ? 0.9008646462833698 :
	+ cycle < 8 ? 0.7314925316712548 :
	+ cycle < 9 ? 1.2642660758239015 :
	+ cycle < 10 ? 1.0636582492824203 :
	+ cycle < 11 ? 1.479666307830646 :
	+ cycle < 12 ? 1.193277740578427 :
	+ cycle < 13 ? 1.2151813628171217 :
	+ cycle < 14 ? 1.015909843427309 :
	+ cycle < 15 ? 0.9231568936553863 :
	+ cycle < 16 ? 0.9872546964817565 :
	+ cycle < 17 ? 1.3623986180076466 :
	+ cycle < 18 ? 0.764838971378902 :
	+ cycle < 19 ? 1.0009564898103531 :
	+ cycle < 20 ? 1.6593860882622908 :
	+ cycle < 21 ? 1.0947641436897622 :
	+ cycle < 22 ? 1.1172954851629469 :
	+ cycle < 23 ? 1.7926469544941832 :
	+ cycle < 24 ? 1.6992911262279389 :
	+ cycle < 25 ? 1.1285230217254303 :
	+ cycle < 26 ? 1.0103192514242003 :
	+ cycle < 27 ? 1.0296803990781762 :
	+ cycle < 28 ? 0.6847382347659214 :
	+ cycle < 29 ? 0.6714712184597378 :
	+ cycle < 30 ? 1.0388273293807613 :
	+ cycle < 31 ? 1.109426575725779 :
	+ cycle < 32 ? 0.2738376561790138 :
	+ cycle < 33 ? 1.1869148419903035 :
	+ cycle < 34 ? 0.9074903368371762 :
	+ cycle < 35 ? 0.8456812453595766 :
	+ cycle < 36 ? 0.30223710662078096 :
	+ cycle < 37 ? 1.26763574601318 :
	+ cycle < 38 ? 1.2228713043778807 :
	+ cycle < 39 ? 1.0864338092740229 :
	+ cycle < 40 ? 1.2041520130261096 :
	+ cycle < 41 ? 1.0888491609632616 :
	+ cycle < 42 ? 0.46301126450719776 :
	+ cycle < 43 ? 0.9855595360890107 :
	+ cycle < 44 ? 1.76238236267668 :
	+ cycle < 45 ? 1.9820678231139024 :
	+ cycle < 46 ? 1.9949050641529622 :
	+ cycle < 47 ? 0.4756211535393189 :
	+ cycle < 48 ? 1.3013764733948507 :
	+ cycle < 49 ? 1.245833993557832 :
	+ cycle < 50 ? 1.5839658727030432 :
	+ cycle < 51 ? 0.9703091950622664 :
	+ cycle < 52 ? 1.116503445186708 :
	+ cycle < 53 ? 1.0736176678264437 :
	+ cycle < 54 ? 1.1301527801339484 :
	+ cycle < 55 ? 0.8508500463359859 :
	+ cycle < 56 ? 0.9613417069867372 :
	+ cycle < 57 ? 1.2432449849983391 :
	+ cycle < 58 ? 1.6060836436204906 :
	+ cycle < 59 ? 1.5220626010909366 :
	+ cycle < 60 ? 0.7432276446706381 :
	+ cycle < 61 ? 0.34500199027676237 :
	+ cycle < 62 ? 0.3834148591304928 :
	+ cycle < 63 ? 1.29034827530093 :
	+ cycle < 64 ? 1.0995630211988205 :
	+ cycle < 65 ? 0.9575832401456978 :
	+ cycle < 66 ? 0.8785722414758012 :
	+ cycle < 67 ? 0.6203532759618513 :
	+ cycle < 68 ? 1.0146430898020125 :
	+ cycle < 69 ? 0.8416966462171374 :
	+ cycle < 70 ? 1.0808866156279515 :
	+ cycle < 71 ? 0.9456988219089482 :
	+ cycle < 72 ? -0.16275267399847082 :
	+ cycle < 73 ? 1.3535535142056905 :
	+ cycle < 74 ? 1.0331430906880674 :
	+ cycle < 75 ? 1.4653634342752653 :
	+ cycle < 76 ? 0.6514296263067627 :
	+ cycle < 77 ? 0.26506293774269807 :
	+ cycle < 78 ? 1.5449872573699612 :
	+ cycle < 79 ? 1.1551156705184507 :
	+ cycle < 80 ? 0.40944066965890136 :
	+ cycle < 81 ? 1.1958518133289657 :
	+ cycle < 82 ? 0.5204304997121176 :
	+ cycle < 83 ? 0.46774186326146994 :
	+ cycle < 84 ? 1.4166016694329175 :
	+ cycle < 85 ? 0.8972301948210504 :
	+ cycle < 86 ? 0.6833365931950506 :
	+ cycle < 87 ? 1.3043174084894256 :
	+ cycle < 88 ? 1.6415116428699776 :
	+ cycle < 89 ? 1.0813999962497207 :
	+ cycle < 90 ? -0.20679980563915534 :
	+ cycle < 91 ? 0.7097876353920676 :
	+ cycle < 92 ? 1.02493691348582 :
	+ cycle < 93 ? 0.8370912850986614 :
	+ cycle < 94 ? 1.2828091302939926 :
	+ cycle < 95 ? 0.5857402320080116 :
	+ cycle < 96 ? 0.43051773646840386 :
	+ cycle < 97 ? 0.9560572883439327 :
	+ cycle < 98 ? 0.7668410720929361 :
	+ cycle < 99 ? 1.0129718430920387 :
	+ cycle < 100 ? 0.38449881745907977 :
	+ cycle < 101 ? 0.8337364777201703 :
	+ cycle < 102 ? 0.6087932415782247 :
	+ cycle < 103 ? 1.901111249360071 :
	+ cycle < 104 ? 1.6694210470081978 :
	+ cycle < 105 ? 0.9376030724777755 :
	+ cycle < 106 ? 1.0432538689472832 :
	+ cycle < 107 ? 0.8631089213022826 :
	+ cycle < 108 ? 0.9101503921581526 :
	+ cycle < 109 ? 1.597124504346398 :
	+ cycle < 110 ? 0.9192047092200296 :
	+ cycle < 111 ? 0.5870367833874117 :
	+ cycle < 112 ? 0.9261290153937363 :
	+ cycle < 113 ? 1.423908301359143 :
	+ cycle < 114 ? 1.2260809577874516 :
	+ cycle < 115 ? 1.2880661282089005 :
	+ cycle < 116 ? 1.2067568654876322 :
	+ cycle < 117 ? 0.7344114829571092 :
	+ cycle < 118 ? 0.4317530576886003 :
	+ cycle < 119 ? 1.0215429190714282 :
	+ cycle < 1;
}

real cycle_dependent_ron_n_0( real cycle ) {
	return
	+ cycle < 0 ? 1.4445548505651604 :
	+ cycle < 1 ? 1.0709956613439362 :
	+ cycle < 2 ? 1.1061401925243535 :
	+ cycle < 3 ? 1.1855868499324067 :
	+ cycle < 4 ? 0.9638079005846591 :
	+ cycle < 5 ? 1.2677361808756786 :
	+ cycle < 6 ? 0.5651063389157696 :
	+ cycle < 7 ? 1.2463652138828094 :
	+ cycle < 8 ? 1.0548562294432093 :
	+ cycle < 9 ? 0.22481621878741231 :
	+ cycle < 10 ? 1.5546158305849884 :
	+ cycle < 11 ? 0.23965212431112337 :
	+ cycle < 12 ? 0.3702822113833759 :
	+ cycle < 13 ? 0.48992259910744684 :
	+ cycle < 14 ? 0.7154065107779763 :
	+ cycle < 15 ? 0.6344598641920267 :
	+ cycle < 16 ? 0.16063512209229525 :
	+ cycle < 17 ? 0.5311442276191363 :
	+ cycle < 18 ? 0.9929042081162294 :
	+ cycle < 19 ? 1.1467937571458 :
	+ cycle < 20 ? 0.9449383145806385 :
	+ cycle < 21 ? 1.1856486603015084 :
	+ cycle < 22 ? 0.7810686406014903 :
	+ cycle < 23 ? 0.7311369666764205 :
	+ cycle < 24 ? 1.0137787531148328 :
	+ cycle < 25 ? 1.2373568688845726 :
	+ cycle < 26 ? 0.528976001187706 :
	+ cycle < 27 ? 1.1070881377379715 :
	+ cycle < 28 ? 0.7003502221311328 :
	+ cycle < 29 ? 0.7530601010868286 :
	+ cycle < 30 ? 0.9709993802449418 :
	+ cycle < 31 ? 1.3130322843483504 :
	+ cycle < 32 ? 1.0101200941640585 :
	+ cycle < 33 ? 0.792736778277877 :
	+ cycle < 34 ? 0.24720700662481165 :
	+ cycle < 35 ? 0.10767862040163645 :
	+ cycle < 36 ? 1.5226857625072148 :
	+ cycle < 37 ? 1.0586351433832193 :
	+ cycle < 38 ? 1.4843550035028186 :
	+ cycle < 39 ? 0.4861738287134987 :
	+ cycle < 40 ? 1.0238294167406305 :
	+ cycle < 41 ? 0.8585344101016077 :
	+ cycle < 42 ? 1.2035159110444498 :
	+ cycle < 43 ? 1.3106624228766284 :
	+ cycle < 44 ? 0.5494688352049137 :
	+ cycle < 45 ? 0.7907166053253116 :
	+ cycle < 46 ? 0.9714563203371378 :
	+ cycle < 47 ? 0.5135071675787388 :
	+ cycle < 48 ? 0.9629080363973506 :
	+ cycle < 49 ? 1.1224348860995188 :
	+ cycle < 50 ? 1.00734891925463 :
	+ cycle < 51 ? 0.9363280682295156 :
	+ cycle < 52 ? 1.6384674759987843 :
	+ cycle < 53 ? 0.6697730000807997 :
	+ cycle < 54 ? 1.3506666933320752 :
	+ cycle < 55 ? 0.5096533558698035 :
	+ cycle < 56 ? 1.4488835816964687 :
	+ cycle < 57 ? 1.4281922859820813 :
	+ cycle < 58 ? 1.0777758707229264 :
	+ cycle < 59 ? 0.8074036166744102 :
	+ cycle < 60 ? 0.6975159029018725 :
	+ cycle < 61 ? 1.4687676051018654 :
	+ cycle < 62 ? 1.3057364294701315 :
	+ cycle < 63 ? 1.5401295672076647 :
	+ cycle < 64 ? 0.10361315009008554 :
	+ cycle < 65 ? 1.1719926282731299 :
	+ cycle < 66 ? 1.0647182799447423 :
	+ cycle < 67 ? 0.617188466910424 :
	+ cycle < 68 ? 1.1149598941495826 :
	+ cycle < 69 ? 1.1087918854411254 :
	+ cycle < 70 ? 0.9474842171260229 :
	+ cycle < 71 ? 1.4445534530332835 :
	+ cycle < 72 ? 0.8748211822426596 :
	+ cycle < 73 ? 1.3004424407928088 :
	+ cycle < 74 ? 0.9915236626491132 :
	+ cycle < 75 ? 2.061987644572266 :
	+ cycle < 76 ? 0.6842935111080027 :
	+ cycle < 77 ? 0.7169512872570534 :
	+ cycle < 78 ? 0.9957720907896395 :
	+ cycle < 79 ? 0.9257341897991131 :
	+ cycle < 80 ? 0.7270067410827517 :
	+ cycle < 81 ? 1.3538553845594683 :
	+ cycle < 82 ? 0.6905536671916612 :
	+ cycle < 83 ? 0.8433884658195556 :
	+ cycle < 84 ? 1.7117967965626995 :
	+ cycle < 85 ? 0.8045428929678211 :
	+ cycle < 86 ? 1.0520601595793544 :
	+ cycle < 87 ? 1.0107661901970924 :
	+ cycle < 88 ? 1.6874151302535587 :
	+ cycle < 89 ? 1.1002215709818701 :
	+ cycle < 90 ? 0.8173083447911348 :
	+ cycle < 91 ? 1.079189857072016 :
	+ cycle < 92 ? 1.0381548860180079 :
	+ cycle < 93 ? 1.321140507475824 :
	+ cycle < 94 ? 1.5627507229250948 :
	+ cycle < 95 ? 1.5384247019925712 :
	+ cycle < 96 ? 1.827528566712405 :
	+ cycle < 97 ? 0.7001229309860755 :
	+ cycle < 98 ? 0.7820660280583047 :
	+ cycle < 99 ? 0.8941220882248561 :
	+ cycle < 100 ? 0.9281794004295857 :
	+ cycle < 101 ? 0.3800755819108321 :
	+ cycle < 102 ? 0.08469859847775307 :
	+ cycle < 103 ? 1.1042985351483283 :
	+ cycle < 104 ? 0.8844605352096648 :
	+ cycle < 105 ? 1.2240706558262706 :
	+ cycle < 106 ? 1.8431492438190884 :
	+ cycle < 107 ? 0.9985082353406878 :
	+ cycle < 108 ? 0.8548993775849749 :
	+ cycle < 109 ? 0.7450339916216449 :
	+ cycle < 110 ? 0.6613150292103935 :
	+ cycle < 111 ? 0.8730039764941386 :
	+ cycle < 112 ? 0.9641789725954074 :
	+ cycle < 113 ? 1.3041345556828576 :
	+ cycle < 114 ? 1.2239750151294468 :
	+ cycle < 115 ? 0.8415713810655026 :
	+ cycle < 116 ? 0.6604681480676068 :
	+ cycle < 117 ? 0.4788483366701527 :
	+ cycle < 118 ? 0.652084361583555 :
	+ cycle < 119 ? 1.5095280750593614 :
	+ cycle < 1;
}

real cycle_dependent_scl_p_0( real cycle ) {
	return
	+ cycle < 0 ? 3.088022879732161 :
	+ cycle < 1 ? 3.8980751166618886 :
	+ cycle < 2 ? 6.961188679472419 :
	+ cycle < 3 ? 5.494269333666373 :
	+ cycle < 4 ? 6.302788466323979 :
	+ cycle < 5 ? 7.046942034179979 :
	+ cycle < 6 ? 4.145807642293092 :
	+ cycle < 7 ? 4.060645247746419 :
	+ cycle < 8 ? 4.832162079750016 :
	+ cycle < 9 ? 5.523341416169673 :
	+ cycle < 10 ? 6.1832891145302 :
	+ cycle < 11 ? 4.263690737684128 :
	+ cycle < 12 ? 3.3138693021397763 :
	+ cycle < 13 ? 6.773847448579529 :
	+ cycle < 14 ? 5.0771951359225165 :
	+ cycle < 15 ? 5.0997267870895024 :
	+ cycle < 16 ? 4.905097101634902 :
	+ cycle < 17 ? 5.098016196082256 :
	+ cycle < 18 ? 5.042557207736239 :
	+ cycle < 19 ? 4.067243864859006 :
	+ cycle < 20 ? 5.06754588421065 :
	+ cycle < 21 ? 3.8228843168274267 :
	+ cycle < 22 ? 3.73853255641746 :
	+ cycle < 23 ? 6.433072320067938 :
	+ cycle < 24 ? 4.479972621733301 :
	+ cycle < 25 ? 3.790500098551294 :
	+ cycle < 26 ? 4.99889792463328 :
	+ cycle < 27 ? 4.704387966210279 :
	+ cycle < 28 ? 5.092517206055827 :
	+ cycle < 29 ? 5.6437927900731735 :
	+ cycle < 30 ? 4.597247035060569 :
	+ cycle < 31 ? 5.857113500740057 :
	+ cycle < 32 ? 5.020381271624444 :
	+ cycle < 33 ? 5.290152372920205 :
	+ cycle < 34 ? 4.65612420309645 :
	+ cycle < 35 ? 2.335496086651595 :
	+ cycle < 36 ? 5.331207252299724 :
	+ cycle < 37 ? 5.214906457147516 :
	+ cycle < 38 ? 4.93060109688628 :
	+ cycle < 39 ? 5.366950126756633 :
	+ cycle < 40 ? 3.454545868787552 :
	+ cycle < 41 ? 4.084488806835338 :
	+ cycle < 42 ? 6.390553722824023 :
	+ cycle < 43 ? 4.793512019581398 :
	+ cycle < 44 ? 4.863266980391221 :
	+ cycle < 45 ? 6.707521247217175 :
	+ cycle < 46 ? 5.771249933188528 :
	+ cycle < 47 ? 4.8782239268193255 :
	+ cycle < 48 ? 5.495103451268088 :
	+ cycle < 49 ? 5.287084935090251 :
	+ cycle < 50 ? 4.012021985794265 :
	+ cycle < 51 ? 5.922899777199805 :
	+ cycle < 52 ? 5.035909230688142 :
	+ cycle < 53 ? 5.1583531913059035 :
	+ cycle < 54 ? 2.769562936880909 :
	+ cycle < 55 ? 3.300238998903006 :
	+ cycle < 56 ? 4.512068457597181 :
	+ cycle < 57 ? 5.703009958260274 :
	+ cycle < 58 ? 5.7655831433819404 :
	+ cycle < 59 ? 3.9644077792556454 :
	+ cycle < 60 ? 4.651817119847097 :
	+ cycle < 61 ? 4.983835738843413 :
	+ cycle < 62 ? 5.75154730138991 :
	+ cycle < 63 ? 6.288202383569797 :
	+ cycle < 64 ? 5.638361126303845 :
	+ cycle < 65 ? 6.362637555852968 :
	+ cycle < 66 ? 7.15364353899982 :
	+ cycle < 67 ? 4.46964677945846 :
	+ cycle < 68 ? 5.562496075121402 :
	+ cycle < 69 ? 4.003258667886159 :
	+ cycle < 70 ? 4.6832406408806 :
	+ cycle < 71 ? 1.9000914377081681 :
	+ cycle < 72 ? 4.997299679408257 :
	+ cycle < 73 ? 6.230146135269964 :
	+ cycle < 74 ? 5.322074570953906 :
	+ cycle < 75 ? 4.408605626866888 :
	+ cycle < 76 ? 4.725667128219164 :
	+ cycle < 77 ? 4.676346221038413 :
	+ cycle < 78 ? 2.499508637819381 :
	+ cycle < 79 ? 5.962959394463379 :
	+ cycle < 80 ? 4.617795267509576 :
	+ cycle < 81 ? 7.625255816369945 :
	+ cycle < 82 ? 5.912736493962824 :
	+ cycle < 83 ? 5.425212916310986 :
	+ cycle < 84 ? 5.470913800116775 :
	+ cycle < 85 ? 3.73612724986085 :
	+ cycle < 86 ? 5.304414284780991 :
	+ cycle < 87 ? 4.569184937573183 :
	+ cycle < 88 ? 6.160903238685182 :
	+ cycle < 89 ? 3.596308433764844 :
	+ cycle < 90 ? 4.362934728371323 :
	+ cycle < 91 ? 4.1172807709379455 :
	+ cycle < 92 ? 5.499301820331958 :
	+ cycle < 93 ? 5.821380161329617 :
	+ cycle < 94 ? 7.7322644683017945 :
	+ cycle < 95 ? 3.463505208624562 :
	+ cycle < 96 ? 6.233385732099564 :
	+ cycle < 97 ? 4.910806566920477 :
	+ cycle < 98 ? 5.449100026623894 :
	+ cycle < 99 ? 4.293745287272937 :
	+ cycle < 100 ? 6.099532454065106 :
	+ cycle < 101 ? 5.508119638251852 :
	+ cycle < 102 ? 6.486939494128667 :
	+ cycle < 103 ? 4.427253735114959 :
	+ cycle < 104 ? 5.452769340120129 :
	+ cycle < 105 ? 5.459876223198027 :
	+ cycle < 106 ? 6.428608222144252 :
	+ cycle < 107 ? 3.3776573602852715 :
	+ cycle < 108 ? 4.527838406020121 :
	+ cycle < 109 ? 5.516198434668732 :
	+ cycle < 110 ? 5.488354901038683 :
	+ cycle < 111 ? 4.750862914327782 :
	+ cycle < 112 ? 4.380573882825447 :
	+ cycle < 113 ? 4.816411068426334 :
	+ cycle < 114 ? 3.7284575360353056 :
	+ cycle < 115 ? 5.5163794753757855 :
	+ cycle < 116 ? 5.918800772483706 :
	+ cycle < 117 ? 6.850801523297804 :
	+ cycle < 118 ? 5.419538237952477 :
	+ cycle < 119 ? 5.751525057311288 :
	+ cycle < 5;
}

real cycle_dependent_scl_n_0( real cycle ) {
	return
	+ cycle < 0 ? 7.486483060598008 :
	+ cycle < 1 ? 8.51403640726397 :
	+ cycle < 2 ? 9.346037108013032 :
	+ cycle < 3 ? 4.445274476671493 :
	+ cycle < 4 ? 7.447141698660744 :
	+ cycle < 5 ? 8.263291388682115 :
	+ cycle < 6 ? 7.394537263764371 :
	+ cycle < 7 ? 8.055319215584237 :
	+ cycle < 8 ? 5.462865636683671 :
	+ cycle < 9 ? 6.157875128283175 :
	+ cycle < 10 ? 8.82294228913108 :
	+ cycle < 11 ? 6.691421724107164 :
	+ cycle < 12 ? 6.708300588329024 :
	+ cycle < 13 ? 6.2119103830949935 :
	+ cycle < 14 ? 6.474899716551755 :
	+ cycle < 15 ? 6.1701537765651215 :
	+ cycle < 16 ? 8.700117137257326 :
	+ cycle < 17 ? 6.010153165231755 :
	+ cycle < 18 ? 6.036940359230329 :
	+ cycle < 19 ? 6.9022923391920665 :
	+ cycle < 20 ? 7.529406205908528 :
	+ cycle < 21 ? 7.89876627111601 :
	+ cycle < 22 ? 7.451513022474841 :
	+ cycle < 23 ? 6.167725452496621 :
	+ cycle < 24 ? 9.428682338893783 :
	+ cycle < 25 ? 6.1561734535906085 :
	+ cycle < 26 ? 6.067499877517482 :
	+ cycle < 27 ? 7.156863481708448 :
	+ cycle < 28 ? 9.199058509106294 :
	+ cycle < 29 ? 6.350419915714312 :
	+ cycle < 30 ? 6.861112452406422 :
	+ cycle < 31 ? 6.3953526487532875 :
	+ cycle < 32 ? 6.5541143145965215 :
	+ cycle < 33 ? 8.775773952165649 :
	+ cycle < 34 ? 8.569451554172353 :
	+ cycle < 35 ? 6.675001471067254 :
	+ cycle < 36 ? 5.266038264104763 :
	+ cycle < 37 ? 7.766512760454845 :
	+ cycle < 38 ? 5.341662733656075 :
	+ cycle < 39 ? 8.589981985979026 :
	+ cycle < 40 ? 6.654340009801038 :
	+ cycle < 41 ? 7.156540698413218 :
	+ cycle < 42 ? 6.525952184807201 :
	+ cycle < 43 ? 7.733376407355938 :
	+ cycle < 44 ? 6.165316076950139 :
	+ cycle < 45 ? 5.7867385231045185 :
	+ cycle < 46 ? 7.6870305222358315 :
	+ cycle < 47 ? 7.821108612384308 :
	+ cycle < 48 ? 4.963787265858132 :
	+ cycle < 49 ? 6.262976655503046 :
	+ cycle < 50 ? 7.117799660385569 :
	+ cycle < 51 ? 7.957649582775319 :
	+ cycle < 52 ? 5.872317386991574 :
	+ cycle < 53 ? 6.080447941915784 :
	+ cycle < 54 ? 7.082674738764316 :
	+ cycle < 55 ? 8.005901036873658 :
	+ cycle < 56 ? 8.950170150670225 :
	+ cycle < 57 ? 8.449601618217379 :
	+ cycle < 58 ? 8.122351312806995 :
	+ cycle < 59 ? 6.189083513582534 :
	+ cycle < 60 ? 8.364278495521626 :
	+ cycle < 61 ? 7.58295638792395 :
	+ cycle < 62 ? 6.3339163556322395 :
	+ cycle < 63 ? 8.351950784081328 :
	+ cycle < 64 ? 8.302320560059284 :
	+ cycle < 65 ? 7.77367465105601 :
	+ cycle < 66 ? 7.046199739014263 :
	+ cycle < 67 ? 7.860914253712797 :
	+ cycle < 68 ? 6.454866112459466 :
	+ cycle < 69 ? 6.5669147592612545 :
	+ cycle < 70 ? 4.825466179229357 :
	+ cycle < 71 ? 6.259862225827237 :
	+ cycle < 72 ? 8.142625478608442 :
	+ cycle < 73 ? 6.809310318099864 :
	+ cycle < 74 ? 6.497849750224959 :
	+ cycle < 75 ? 5.049420482939341 :
	+ cycle < 76 ? 7.371016407624295 :
	+ cycle < 77 ? 5.281142043489333 :
	+ cycle < 78 ? 6.692996798223927 :
	+ cycle < 79 ? 7.651596530520264 :
	+ cycle < 80 ? 7.441706377206776 :
	+ cycle < 81 ? 7.886626708159535 :
	+ cycle < 82 ? 5.066738914870279 :
	+ cycle < 83 ? 6.883306503316356 :
	+ cycle < 84 ? 8.237786060313733 :
	+ cycle < 85 ? 5.500307300550676 :
	+ cycle < 86 ? 8.978089112797026 :
	+ cycle < 87 ? 7.652659251690513 :
	+ cycle < 88 ? 6.910516732087893 :
	+ cycle < 89 ? 6.197950923089154 :
	+ cycle < 90 ? 7.79167640068372 :
	+ cycle < 91 ? 8.064311390796659 :
	+ cycle < 92 ? 6.8487395865228216 :
	+ cycle < 93 ? 6.435751577139886 :
	+ cycle < 94 ? 9.067518160592245 :
	+ cycle < 95 ? 8.548499727638587 :
	+ cycle < 96 ? 9.534855048276107 :
	+ cycle < 97 ? 7.917528603217947 :
	+ cycle < 98 ? 4.763679924328387 :
	+ cycle < 99 ? 6.839322452025699 :
	+ cycle < 100 ? 6.717233195231907 :
	+ cycle < 101 ? 6.1453226629540225 :
	+ cycle < 102 ? 7.370440951793104 :
	+ cycle < 103 ? 4.917167577197039 :
	+ cycle < 104 ? 4.8893434607245165 :
	+ cycle < 105 ? 5.847260551448158 :
	+ cycle < 106 ? 6.3992296950110505 :
	+ cycle < 107 ? 8.31552250845515 :
	+ cycle < 108 ? 6.65847995676208 :
	+ cycle < 109 ? 6.652358801591563 :
	+ cycle < 110 ? 7.154600234272088 :
	+ cycle < 111 ? 8.589476523076424 :
	+ cycle < 112 ? 5.158891296325963 :
	+ cycle < 113 ? 8.283371056799188 :
	+ cycle < 114 ? 7.143817557592175 :
	+ cycle < 115 ? 5.321376131354146 :
	+ cycle < 116 ? 6.577105292971893 :
	+ cycle < 117 ? 9.572354581422434 :
	+ cycle < 118 ? 5.451566077023951 :
	+ cycle < 119 ? 5.552226424404056 :
	+ cycle < 7;
}

// File 1

real cycle_dependent_ron_p_1( real cycle ) {
	return
	+ cycle < 0 ? 1.556135254701936 :
	+ cycle < 1 ? 0.9053035456130645 :
	+ cycle < 2 ? 1.0120163618136944 :
	+ cycle < 3 ? 0.7451839576325385 :
	+ cycle < 4 ? 1.012125830045274 :
	+ cycle < 5 ? 1.7125175042866054 :
	+ cycle < 6 ? 0.5398027261325287 :
	+ cycle < 7 ? 0.5187885920314299 :
	+ cycle < 8 ? 1.2388495476986696 :
	+ cycle < 9 ? 1.675654714781523 :
	+ cycle < 10 ? 0.3667398707066958 :
	+ cycle < 11 ? 0.8285974151862284 :
	+ cycle < 12 ? 1.4109869830509914 :
	+ cycle < 13 ? 1.3605833597289145 :
	+ cycle < 14 ? 0.7661095442322012 :
	+ cycle < 15 ? 0.6176217143893394 :
	+ cycle < 16 ? 1.0607941689130573 :
	+ cycle < 17 ? 0.30082853666152065 :
	+ cycle < 18 ? 1.252421849217705 :
	+ cycle < 19 ? 1.288939582290994 :
	+ cycle < 20 ? 1.2907103024539688 :
	+ cycle < 21 ? 1.4613325229152359 :
	+ cycle < 22 ? 0.4990684653602875 :
	+ cycle < 23 ? 0.9615262001157593 :
	+ cycle < 24 ? 1.113976328962137 :
	+ cycle < 25 ? 2.0731422358960403 :
	+ cycle < 26 ? 1.5192068407750943 :
	+ cycle < 27 ? 0.9102206811303675 :
	+ cycle < 28 ? 0.44477023082351563 :
	+ cycle < 29 ? 1.5622471748804136 :
	+ cycle < 30 ? 1.3444885801027229 :
	+ cycle < 31 ? 0.7361129662193797 :
	+ cycle < 32 ? 1.0788869156287078 :
	+ cycle < 33 ? 1.4876473568996678 :
	+ cycle < 34 ? 1.2052255774512655 :
	+ cycle < 35 ? 0.8477225672478567 :
	+ cycle < 36 ? 1.4442528659821041 :
	+ cycle < 37 ? 0.5366017911317156 :
	+ cycle < 38 ? 1.295489011487242 :
	+ cycle < 39 ? 0.6567975055197453 :
	+ cycle < 40 ? 1.5492625022735536 :
	+ cycle < 41 ? 1.079347536515746 :
	+ cycle < 42 ? 0.6665790283185606 :
	+ cycle < 43 ? 1.090787979201499 :
	+ cycle < 44 ? 0.8749175808614388 :
	+ cycle < 45 ? 1.3151237392437738 :
	+ cycle < 46 ? 1.1325418953754338 :
	+ cycle < 47 ? 1.2743195842315092 :
	+ cycle < 48 ? 0.9393021706944369 :
	+ cycle < 49 ? 0.77289093392831 :
	+ cycle < 50 ? 0.7277471103817446 :
	+ cycle < 51 ? 1.4374571582344153 :
	+ cycle < 52 ? 0.7834577053521905 :
	+ cycle < 53 ? 1.7251642624173544 :
	+ cycle < 54 ? 0.79308315694149 :
	+ cycle < 55 ? 0.9888034866152774 :
	+ cycle < 56 ? 0.9745537414264345 :
	+ cycle < 57 ? 0.8895412849297893 :
	+ cycle < 58 ? 1.081568122729682 :
	+ cycle < 59 ? 1.095614660409574 :
	+ cycle < 60 ? 1.0233855438298867 :
	+ cycle < 61 ? 0.7270586275528013 :
	+ cycle < 62 ? 0.5441727411718873 :
	+ cycle < 63 ? 0.7441296822720208 :
	+ cycle < 64 ? 1.2548753091291511 :
	+ cycle < 65 ? 0.724818465078173 :
	+ cycle < 66 ? 1.6608118970630774 :
	+ cycle < 67 ? 0.7104580106220126 :
	+ cycle < 68 ? 0.8044963930138938 :
	+ cycle < 69 ? 0.8604149421168564 :
	+ cycle < 70 ? 0.9142645726324957 :
	+ cycle < 71 ? 0.7290470903825677 :
	+ cycle < 72 ? 1.282104215750059 :
	+ cycle < 73 ? 0.39663230378870695 :
	+ cycle < 74 ? 0.4197511577197376 :
	+ cycle < 75 ? 0.6631164354087227 :
	+ cycle < 76 ? 1.0638925064897558 :
	+ cycle < 77 ? 0.9525234718023577 :
	+ cycle < 78 ? 1.083219512185256 :
	+ cycle < 79 ? 0.9030051553719178 :
	+ cycle < 80 ? 1.1541444020285927 :
	+ cycle < 81 ? 1.2702475711823922 :
	+ cycle < 82 ? 1.553730110392452 :
	+ cycle < 83 ? 1.1978215682695288 :
	+ cycle < 84 ? 1.4367748059156353 :
	+ cycle < 85 ? 1.517336115785381 :
	+ cycle < 86 ? 0.12876632240942687 :
	+ cycle < 87 ? 0.5017238413697349 :
	+ cycle < 88 ? 0.69683779455714 :
	+ cycle < 89 ? 1.051369759603988 :
	+ cycle < 90 ? 0.889532043724635 :
	+ cycle < 91 ? 0.7389353783974633 :
	+ cycle < 92 ? 1.9843984152140708 :
	+ cycle < 93 ? 1.0294048635670745 :
	+ cycle < 94 ? 1.1869467085244245 :
	+ cycle < 95 ? 0.042748065820429115 :
	+ cycle < 96 ? 1.3877320763240155 :
	+ cycle < 97 ? 0.6932489936635207 :
	+ cycle < 98 ? 0.12646347613034514 :
	+ cycle < 99 ? 0.7098772724470369 :
	+ cycle < 100 ? 0.7790356602807714 :
	+ cycle < 101 ? 0.6027711641944276 :
	+ cycle < 102 ? 1.1489001753355899 :
	+ cycle < 103 ? 0.8097024321999277 :
	+ cycle < 104 ? 1.0318090317282533 :
	+ cycle < 105 ? 1.0980815569113935 :
	+ cycle < 106 ? 0.6583572263905468 :
	+ cycle < 107 ? 0.42267053801978205 :
	+ cycle < 108 ? 0.7049811678284277 :
	+ cycle < 109 ? 0.28282575969306023 :
	+ cycle < 110 ? 0.45947500023778653 :
	+ cycle < 111 ? 0.3539901102763313 :
	+ cycle < 112 ? 1.3796375902728915 :
	+ cycle < 113 ? 0.5725423379770138 :
	+ cycle < 114 ? 1.158763067065216 :
	+ cycle < 115 ? 1.1551150585884964 :
	+ cycle < 116 ? 1.319613087340283 :
	+ cycle < 117 ? 1.133625388511847 :
	+ cycle < 118 ? 1.4818449220168142 :
	+ cycle < 119 ? 1.222318169983592 :
	+ cycle < 1;
}

real cycle_dependent_ron_n_1( real cycle ) {
	return
	+ cycle < 0 ? 0.6931625900422707 :
	+ cycle < 1 ? 1.0662593841030792 :
	+ cycle < 2 ? 1.4600752554438081 :
	+ cycle < 3 ? 0.7078729887540673 :
	+ cycle < 4 ? 0.5919165127589541 :
	+ cycle < 5 ? 0.8759903846842428 :
	+ cycle < 6 ? 0.9315041697621739 :
	+ cycle < 7 ? 0.9215368002836252 :
	+ cycle < 8 ? 1.3696426898094884 :
	+ cycle < 9 ? 0.48353257520784676 :
	+ cycle < 10 ? 1.0537739723050032 :
	+ cycle < 11 ? 1.5388170417944016 :
	+ cycle < 12 ? 0.8270097420597186 :
	+ cycle < 13 ? 1.1601616210023165 :
	+ cycle < 14 ? 1.0698890513637336 :
	+ cycle < 15 ? 0.528103279510004 :
	+ cycle < 16 ? 1.055811318045503 :
	+ cycle < 17 ? 0.14407955558872165 :
	+ cycle < 18 ? 1.085027271074308 :
	+ cycle < 19 ? 1.2359991146542377 :
	+ cycle < 20 ? 1.2936869710758285 :
	+ cycle < 21 ? 1.2935568805859141 :
	+ cycle < 22 ? 0.8501874843924534 :
	+ cycle < 23 ? 0.8519782870816299 :
	+ cycle < 24 ? 0.7353334024903283 :
	+ cycle < 25 ? 0.6768745592258392 :
	+ cycle < 26 ? 1.2417577275214862 :
	+ cycle < 27 ? 1.4467536754498895 :
	+ cycle < 28 ? 1.5140244107162122 :
	+ cycle < 29 ? 0.8939375270998389 :
	+ cycle < 30 ? 0.7475479344416611 :
	+ cycle < 31 ? 0.6799868569228311 :
	+ cycle < 32 ? 0.705817299099393 :
	+ cycle < 33 ? 0.8800005039931332 :
	+ cycle < 34 ? 1.0631071627078488 :
	+ cycle < 35 ? 0.7364263339028465 :
	+ cycle < 36 ? 0.7850523333810563 :
	+ cycle < 37 ? 1.0663304365822805 :
	+ cycle < 38 ? 1.0733433929503977 :
	+ cycle < 39 ? 0.9079094548328603 :
	+ cycle < 40 ? 0.6017633580599746 :
	+ cycle < 41 ? 0.3176973895018754 :
	+ cycle < 42 ? 0.34051784299380605 :
	+ cycle < 43 ? 1.387308197565853 :
	+ cycle < 44 ? 0.8435978163498202 :
	+ cycle < 45 ? 1.4309879790850322 :
	+ cycle < 46 ? 0.9188860464016888 :
	+ cycle < 47 ? 1.2036381823683773 :
	+ cycle < 48 ? 0.6840918043103906 :
	+ cycle < 49 ? 0.8315608541686664 :
	+ cycle < 50 ? 1.553310613587172 :
	+ cycle < 51 ? 0.12511616141509796 :
	+ cycle < 52 ? 1.472429884774795 :
	+ cycle < 53 ? 0.5355087593314425 :
	+ cycle < 54 ? 0.9714727426942137 :
	+ cycle < 55 ? 0.49044969104276614 :
	+ cycle < 56 ? 0.9634873959094161 :
	+ cycle < 57 ? 0.10252234742820532 :
	+ cycle < 58 ? 1.0788392827445608 :
	+ cycle < 59 ? 0.9970467848968726 :
	+ cycle < 60 ? 1.370789462458929 :
	+ cycle < 61 ? 1.3093698351145073 :
	+ cycle < 62 ? 1.1539137540738538 :
	+ cycle < 63 ? 0.8185466321492959 :
	+ cycle < 64 ? 1.3353148818951892 :
	+ cycle < 65 ? 0.6135343532025073 :
	+ cycle < 66 ? 1.484786282053328 :
	+ cycle < 67 ? 1.51342235274688 :
	+ cycle < 68 ? 1.3101837613379725 :
	+ cycle < 69 ? 1.0792555593106565 :
	+ cycle < 70 ? 1.120555477044401 :
	+ cycle < 71 ? 0.7662139628307213 :
	+ cycle < 72 ? 1.2762505204286374 :
	+ cycle < 73 ? 0.8511149713591997 :
	+ cycle < 74 ? 0.7233430683415689 :
	+ cycle < 75 ? 1.4684799183475288 :
	+ cycle < 76 ? 1.1518518771855697 :
	+ cycle < 77 ? 1.8045824007814408 :
	+ cycle < 78 ? 0.23378202998569952 :
	+ cycle < 79 ? 1.0522057154104019 :
	+ cycle < 80 ? 0.8920688478912859 :
	+ cycle < 81 ? 1.0669555330619258 :
	+ cycle < 82 ? 1.699015635078052 :
	+ cycle < 83 ? 1.3316808012437753 :
	+ cycle < 84 ? 0.7186671577216357 :
	+ cycle < 85 ? 0.6408811533027385 :
	+ cycle < 86 ? 1.0336659160249673 :
	+ cycle < 87 ? 1.0954498438217684 :
	+ cycle < 88 ? 1.2716057273425552 :
	+ cycle < 89 ? 0.687231260242408 :
	+ cycle < 90 ? 0.8465214896024409 :
	+ cycle < 91 ? 0.833263163273867 :
	+ cycle < 92 ? 0.9580873943456386 :
	+ cycle < 93 ? 1.684165806830475 :
	+ cycle < 94 ? 1.6267927869771117 :
	+ cycle < 95 ? 1.3089687992063825 :
	+ cycle < 96 ? 0.9445504976636143 :
	+ cycle < 97 ? 1.2646917001168234 :
	+ cycle < 98 ? 1.2068067930142932 :
	+ cycle < 99 ? 0.7323619924695486 :
	+ cycle < 100 ? 1.0249446753252198 :
	+ cycle < 101 ? 0.8580671007626762 :
	+ cycle < 102 ? 1.0026513477475245 :
	+ cycle < 103 ? 0.9139809812494576 :
	+ cycle < 104 ? 0.7318848892782824 :
	+ cycle < 105 ? 0.34464075182481935 :
	+ cycle < 106 ? 1.569302876005574 :
	+ cycle < 107 ? 1.1688450144936686 :
	+ cycle < 108 ? 1.159269516306704 :
	+ cycle < 109 ? 0.6545012530419316 :
	+ cycle < 110 ? 1.0952903344275875 :
	+ cycle < 111 ? 1.593634873223876 :
	+ cycle < 112 ? 0.8004741016991863 :
	+ cycle < 113 ? 1.1918699568512852 :
	+ cycle < 114 ? 1.3148418485289648 :
	+ cycle < 115 ? 1.7416663101625036 :
	+ cycle < 116 ? 1.636097811202779 :
	+ cycle < 117 ? 0.3959045669599911 :
	+ cycle < 118 ? 1.365025969058152 :
	+ cycle < 119 ? 0.4897544383034367 :
	+ cycle < 1;
}

real cycle_dependent_scl_p_1( real cycle ) {
	return
	+ cycle < 0 ? 4.704857456106481 :
	+ cycle < 1 ? 6.1511319887859495 :
	+ cycle < 2 ? 4.007120668658753 :
	+ cycle < 3 ? 3.9614929330996644 :
	+ cycle < 4 ? 6.229334669598444 :
	+ cycle < 5 ? 5.120895570969288 :
	+ cycle < 6 ? 3.10549559380199 :
	+ cycle < 7 ? 4.433635674666305 :
	+ cycle < 8 ? 4.701013312313051 :
	+ cycle < 9 ? 2.738617329031804 :
	+ cycle < 10 ? 4.227368380328479 :
	+ cycle < 11 ? 4.596854610709368 :
	+ cycle < 12 ? 3.5961427346237635 :
	+ cycle < 13 ? 5.69714791449623 :
	+ cycle < 14 ? 5.286847593884741 :
	+ cycle < 15 ? 5.384721289504007 :
	+ cycle < 16 ? 4.541728172044993 :
	+ cycle < 17 ? 5.079491855180947 :
	+ cycle < 18 ? 5.741437519008173 :
	+ cycle < 19 ? 4.610803677560916 :
	+ cycle < 20 ? 4.67700496344719 :
	+ cycle < 21 ? 4.168288480666865 :
	+ cycle < 22 ? 5.502453458976547 :
	+ cycle < 23 ? 5.23481908082176 :
	+ cycle < 24 ? 3.0259465829750987 :
	+ cycle < 25 ? 4.736863491273615 :
	+ cycle < 26 ? 3.911258292257787 :
	+ cycle < 27 ? 5.3765107776461525 :
	+ cycle < 28 ? 5.869377087043331 :
	+ cycle < 29 ? 6.171678094134616 :
	+ cycle < 30 ? 3.4204275829788915 :
	+ cycle < 31 ? 5.231065945799593 :
	+ cycle < 32 ? 4.849887629942084 :
	+ cycle < 33 ? 4.732277630938525 :
	+ cycle < 34 ? 3.6805794087989243 :
	+ cycle < 35 ? 4.75330570800219 :
	+ cycle < 36 ? 4.2732347367786865 :
	+ cycle < 37 ? 4.4089268799741665 :
	+ cycle < 38 ? 3.1669727338673233 :
	+ cycle < 39 ? 5.908984534349207 :
	+ cycle < 40 ? 5.754640439847381 :
	+ cycle < 41 ? 4.967920794864033 :
	+ cycle < 42 ? 4.508151829871052 :
	+ cycle < 43 ? 4.192197792481316 :
	+ cycle < 44 ? 5.397766035795931 :
	+ cycle < 45 ? 4.0389563230638315 :
	+ cycle < 46 ? 4.389700924435041 :
	+ cycle < 47 ? 4.8157172186851325 :
	+ cycle < 48 ? 4.95004800369819 :
	+ cycle < 49 ? 3.8371618891917123 :
	+ cycle < 50 ? 3.8831253722829437 :
	+ cycle < 51 ? 6.009977647286014 :
	+ cycle < 52 ? 4.524296382217145 :
	+ cycle < 53 ? 5.540014965704641 :
	+ cycle < 54 ? 4.861177671198368 :
	+ cycle < 55 ? 5.7115781194641535 :
	+ cycle < 56 ? 4.549297457706822 :
	+ cycle < 57 ? 5.638450319017552 :
	+ cycle < 58 ? 6.16677888306577 :
	+ cycle < 59 ? 4.192423254803144 :
	+ cycle < 60 ? 4.220602864077771 :
	+ cycle < 61 ? 5.911699714831678 :
	+ cycle < 62 ? 4.671500077225002 :
	+ cycle < 63 ? 4.759794518468484 :
	+ cycle < 64 ? 2.7737956259631855 :
	+ cycle < 65 ? 4.773391584357263 :
	+ cycle < 66 ? 4.918245655293772 :
	+ cycle < 67 ? 3.440761438033819 :
	+ cycle < 68 ? 4.803191443252206 :
	+ cycle < 69 ? 4.141385239997312 :
	+ cycle < 70 ? 4.451264061055821 :
	+ cycle < 71 ? 4.997975601763891 :
	+ cycle < 72 ? 5.199412123513345 :
	+ cycle < 73 ? 4.341846665124933 :
	+ cycle < 74 ? 6.829889508894205 :
	+ cycle < 75 ? 5.677885957642861 :
	+ cycle < 76 ? 5.367246600865484 :
	+ cycle < 77 ? 5.816404681145091 :
	+ cycle < 78 ? 4.268033020758631 :
	+ cycle < 79 ? 5.334951055505639 :
	+ cycle < 80 ? 4.3312460294240696 :
	+ cycle < 81 ? 5.365116696613241 :
	+ cycle < 82 ? 3.981543156269291 :
	+ cycle < 83 ? 5.665255681254242 :
	+ cycle < 84 ? 6.180503714978221 :
	+ cycle < 85 ? 4.731839148222062 :
	+ cycle < 86 ? 4.472517922834229 :
	+ cycle < 87 ? 4.839327216892457 :
	+ cycle < 88 ? 3.9261351324677993 :
	+ cycle < 89 ? 5.636307893422722 :
	+ cycle < 90 ? 4.5519984406001175 :
	+ cycle < 91 ? 4.907533820882572 :
	+ cycle < 92 ? 4.920679290685975 :
	+ cycle < 93 ? 4.911249556378256 :
	+ cycle < 94 ? 4.010847744227197 :
	+ cycle < 95 ? 5.787768664497668 :
	+ cycle < 96 ? 4.629250576635202 :
	+ cycle < 97 ? 5.296885464557514 :
	+ cycle < 98 ? 5.128633421348077 :
	+ cycle < 99 ? 4.772040873923574 :
	+ cycle < 100 ? 6.491424738013549 :
	+ cycle < 101 ? 4.375085696901731 :
	+ cycle < 102 ? 4.968001557488702 :
	+ cycle < 103 ? 4.137407020416915 :
	+ cycle < 104 ? 4.5550335992151645 :
	+ cycle < 105 ? 5.08111961026997 :
	+ cycle < 106 ? 3.4500693144779255 :
	+ cycle < 107 ? 4.140934746153186 :
	+ cycle < 108 ? 6.446150918630369 :
	+ cycle < 109 ? 5.0929045694643404 :
	+ cycle < 110 ? 5.966675408007992 :
	+ cycle < 111 ? 3.9979499900572852 :
	+ cycle < 112 ? 4.698421003188406 :
	+ cycle < 113 ? 4.365402227904607 :
	+ cycle < 114 ? 4.1006046427438845 :
	+ cycle < 115 ? 6.471417472126372 :
	+ cycle < 116 ? 4.998071391375186 :
	+ cycle < 117 ? 4.48686602417961 :
	+ cycle < 118 ? 6.175081452733995 :
	+ cycle < 119 ? 5.4957394491726275 :
	+ cycle < 5;
}

real cycle_dependent_scl_n_1( real cycle ) {
	return
	+ cycle < 0 ? 8.84184033036391 :
	+ cycle < 1 ? 6.842156291820924 :
	+ cycle < 2 ? 7.613693190876968 :
	+ cycle < 3 ? 7.378066760276146 :
	+ cycle < 4 ? 6.952956760389621 :
	+ cycle < 5 ? 7.569147405427628 :
	+ cycle < 6 ? 9.373022157497306 :
	+ cycle < 7 ? 6.782188090771253 :
	+ cycle < 8 ? 6.428186695689201 :
	+ cycle < 9 ? 4.930281037796271 :
	+ cycle < 10 ? 4.292254136118608 :
	+ cycle < 11 ? 5.0644368455383955 :
	+ cycle < 12 ? 8.557632208145991 :
	+ cycle < 13 ? 9.479569116590154 :
	+ cycle < 14 ? 6.456573078966181 :
	+ cycle < 15 ? 6.970960746173958 :
	+ cycle < 16 ? 7.290051427979287 :
	+ cycle < 17 ? 6.34597788492907 :
	+ cycle < 18 ? 6.8168583699480205 :
	+ cycle < 19 ? 7.8338320032238995 :
	+ cycle < 20 ? 9.045470126234111 :
	+ cycle < 21 ? 10.061940433024096 :
	+ cycle < 22 ? 6.573230032944183 :
	+ cycle < 23 ? 6.984856995824056 :
	+ cycle < 24 ? 7.260069002305115 :
	+ cycle < 25 ? 8.466681242898378 :
	+ cycle < 26 ? 6.023765850373115 :
	+ cycle < 27 ? 7.015984566304654 :
	+ cycle < 28 ? 5.939826943586465 :
	+ cycle < 29 ? 8.196779170072647 :
	+ cycle < 30 ? 5.7587188713731665 :
	+ cycle < 31 ? 7.3575427603152335 :
	+ cycle < 32 ? 6.0210718875795095 :
	+ cycle < 33 ? 5.284540181728062 :
	+ cycle < 34 ? 6.7736589743954125 :
	+ cycle < 35 ? 7.89072755006797 :
	+ cycle < 36 ? 7.368311648992297 :
	+ cycle < 37 ? 6.059747482768031 :
	+ cycle < 38 ? 8.06968169799843 :
	+ cycle < 39 ? 5.7750740325877405 :
	+ cycle < 40 ? 5.7244730645455295 :
	+ cycle < 41 ? 6.653713047961146 :
	+ cycle < 42 ? 5.759797448519953 :
	+ cycle < 43 ? 5.490250183173727 :
	+ cycle < 44 ? 5.886637140480799 :
	+ cycle < 45 ? 7.453383604083904 :
	+ cycle < 46 ? 7.018906966364692 :
	+ cycle < 47 ? 9.64966513884466 :
	+ cycle < 48 ? 8.035020605986318 :
	+ cycle < 49 ? 7.623287161137576 :
	+ cycle < 50 ? 7.0135076839417225 :
	+ cycle < 51 ? 5.453966349526068 :
	+ cycle < 52 ? 6.203588529097671 :
	+ cycle < 53 ? 7.153540635188822 :
	+ cycle < 54 ? 7.458606176560836 :
	+ cycle < 55 ? 8.816859683679443 :
	+ cycle < 56 ? 5.485282309995953 :
	+ cycle < 57 ? 6.469355609987644 :
	+ cycle < 58 ? 7.23373751560254 :
	+ cycle < 59 ? 9.820490379144475 :
	+ cycle < 60 ? 6.060630427461195 :
	+ cycle < 61 ? 7.68370965407106 :
	+ cycle < 62 ? 5.0197076039688024 :
	+ cycle < 63 ? 8.05949753302278 :
	+ cycle < 64 ? 6.689344485189182 :
	+ cycle < 65 ? 6.863486936175374 :
	+ cycle < 66 ? 7.694207331001455 :
	+ cycle < 67 ? 7.02443379502977 :
	+ cycle < 68 ? 6.048672698328602 :
	+ cycle < 69 ? 6.607603283920007 :
	+ cycle < 70 ? 7.437292922937316 :
	+ cycle < 71 ? 2.603893923619128 :
	+ cycle < 72 ? 6.190198714414988 :
	+ cycle < 73 ? 7.470123943672353 :
	+ cycle < 74 ? 7.0448471853402035 :
	+ cycle < 75 ? 4.684450873493886 :
	+ cycle < 76 ? 6.26758754323215 :
	+ cycle < 77 ? 8.222471041904678 :
	+ cycle < 78 ? 9.391262577081616 :
	+ cycle < 79 ? 8.477893644644414 :
	+ cycle < 80 ? 6.672478646030963 :
	+ cycle < 81 ? 6.612388231100424 :
	+ cycle < 82 ? 8.834784947841609 :
	+ cycle < 83 ? 7.422587800688154 :
	+ cycle < 84 ? 7.213279849004437 :
	+ cycle < 85 ? 5.7294015399975375 :
	+ cycle < 86 ? 6.052086474946001 :
	+ cycle < 87 ? 5.209731756217182 :
	+ cycle < 88 ? 7.418184974594034 :
	+ cycle < 89 ? 7.160889893664963 :
	+ cycle < 90 ? 4.539958305312897 :
	+ cycle < 91 ? 10.34404454564789 :
	+ cycle < 92 ? 7.644564516226999 :
	+ cycle < 93 ? 6.790420637631515 :
	+ cycle < 94 ? 4.815935874373231 :
	+ cycle < 95 ? 5.9930119604193015 :
	+ cycle < 96 ? 5.207786187902622 :
	+ cycle < 97 ? 6.53763183814798 :
	+ cycle < 98 ? 8.175683052702897 :
	+ cycle < 99 ? 8.000810623343677 :
	+ cycle < 100 ? 6.387256549291695 :
	+ cycle < 101 ? 7.776498680070379 :
	+ cycle < 102 ? 6.053463478976148 :
	+ cycle < 103 ? 6.8579334151080005 :
	+ cycle < 104 ? 7.167936557525374 :
	+ cycle < 105 ? 7.568852347151885 :
	+ cycle < 106 ? 8.275113812637418 :
	+ cycle < 107 ? 8.12308320219838 :
	+ cycle < 108 ? 8.142117430667392 :
	+ cycle < 109 ? 9.210861381804696 :
	+ cycle < 110 ? 7.257744366218201 :
	+ cycle < 111 ? 5.753191964514057 :
	+ cycle < 112 ? 7.476058155363425 :
	+ cycle < 113 ? 9.396775790163431 :
	+ cycle < 114 ? 6.579705158542977 :
	+ cycle < 115 ? 5.515430611033102 :
	+ cycle < 116 ? 5.608334218161659 :
	+ cycle < 117 ? 3.982993785567938 :
	+ cycle < 118 ? 7.922444882251582 :
	+ cycle < 119 ? 8.939236077198537 :
	+ cycle < 7;
}

// File 2

real cycle_dependent_ron_p_2( real cycle ) {
	return
	+ cycle < 0 ? 0.8786292585683421 :
	+ cycle < 1 ? 0.3377130828704744 :
	+ cycle < 2 ? 1.2305156056239877 :
	+ cycle < 3 ? 1.1601289247426343 :
	+ cycle < 4 ? 1.3787095973189618 :
	+ cycle < 5 ? 1.1311787564610447 :
	+ cycle < 6 ? 0.9245479374420618 :
	+ cycle < 7 ? 1.3669711247582659 :
	+ cycle < 8 ? 1.1545144109532137 :
	+ cycle < 9 ? 0.9228560613376477 :
	+ cycle < 10 ? 1.2982005219564159 :
	+ cycle < 11 ? 1.7393262779987921 :
	+ cycle < 12 ? 1.0153105808967942 :
	+ cycle < 13 ? 1.30883754024845 :
	+ cycle < 14 ? 0.5069288094180999 :
	+ cycle < 15 ? 0.7001748948041218 :
	+ cycle < 16 ? 1.3252266046275392 :
	+ cycle < 17 ? 0.9849709194735157 :
	+ cycle < 18 ? 1.2962780623032775 :
	+ cycle < 19 ? 0.6655735872579933 :
	+ cycle < 20 ? 0.7551143444756941 :
	+ cycle < 21 ? 1.8011400457653908 :
	+ cycle < 22 ? 0.8514401035565478 :
	+ cycle < 23 ? 0.41565026939126337 :
	+ cycle < 24 ? 1.6029010972127806 :
	+ cycle < 25 ? 0.6613838956958367 :
	+ cycle < 26 ? 0.7750781600798436 :
	+ cycle < 27 ? 0.8251747333744566 :
	+ cycle < 28 ? 0.7808972389712452 :
	+ cycle < 29 ? 0.31541965445366027 :
	+ cycle < 30 ? 1.3783198805349128 :
	+ cycle < 31 ? 0.8491171339201662 :
	+ cycle < 32 ? 0.667229314953989 :
	+ cycle < 33 ? 0.512668371041572 :
	+ cycle < 34 ? 1.1913781441490567 :
	+ cycle < 35 ? 0.4500083261047719 :
	+ cycle < 36 ? 1.0077178011155459 :
	+ cycle < 37 ? 0.6709806722070257 :
	+ cycle < 38 ? 1.0726898092237727 :
	+ cycle < 39 ? 0.6560096192611549 :
	+ cycle < 40 ? 1.011082318913486 :
	+ cycle < 41 ? 0.9268825538806216 :
	+ cycle < 42 ? 1.3104819577737126 :
	+ cycle < 43 ? 1.0707695860151658 :
	+ cycle < 44 ? 0.9187234206608137 :
	+ cycle < 45 ? 0.45904017645712214 :
	+ cycle < 46 ? 0.8635659942933143 :
	+ cycle < 47 ? 0.5515161041453551 :
	+ cycle < 48 ? 0.48985267188236314 :
	+ cycle < 49 ? 0.6424939999372297 :
	+ cycle < 50 ? 0.570227174138127 :
	+ cycle < 51 ? 1.356003375072723 :
	+ cycle < 52 ? 1.4435512950087572 :
	+ cycle < 53 ? 1.1036904157278076 :
	+ cycle < 54 ? 1.643260555755926 :
	+ cycle < 55 ? 0.9877643236722189 :
	+ cycle < 56 ? 0.8285529351187535 :
	+ cycle < 57 ? 1.4616319830026776 :
	+ cycle < 58 ? 0.3226304698944985 :
	+ cycle < 59 ? 0.4795202773741053 :
	+ cycle < 60 ? 1.096686151192959 :
	+ cycle < 61 ? 1.275316368447148 :
	+ cycle < 62 ? 0.9301548356652918 :
	+ cycle < 63 ? 1.1764069808483315 :
	+ cycle < 64 ? 0.9845772230087442 :
	+ cycle < 65 ? 0.8453388214383682 :
	+ cycle < 66 ? 0.983050706333096 :
	+ cycle < 67 ? 0.947545001781084 :
	+ cycle < 68 ? 0.5813128822721282 :
	+ cycle < 69 ? 0.7281912751495736 :
	+ cycle < 70 ? 1.5112127967501279 :
	+ cycle < 71 ? 0.943576657699339 :
	+ cycle < 72 ? 0.9892291976555789 :
	+ cycle < 73 ? 0.2944329371045693 :
	+ cycle < 74 ? 1.2921648094310623 :
	+ cycle < 75 ? 1.7164288912826273 :
	+ cycle < 76 ? 1.4183489853239108 :
	+ cycle < 77 ? 1.5569012311432262 :
	+ cycle < 78 ? 0.8788940117806366 :
	+ cycle < 79 ? 1.5524870003055975 :
	+ cycle < 80 ? 0.2918467300934443 :
	+ cycle < 81 ? 1.6526669853677787 :
	+ cycle < 82 ? 0.48830107089262687 :
	+ cycle < 83 ? 0.7482211865557149 :
	+ cycle < 84 ? 0.6337113239120853 :
	+ cycle < 85 ? 1.3751138786368884 :
	+ cycle < 86 ? 0.9296110400440012 :
	+ cycle < 87 ? 0.5367399723798199 :
	+ cycle < 88 ? 1.0841646436599528 :
	+ cycle < 89 ? 1.3381447037459495 :
	+ cycle < 90 ? 1.0777693616085924 :
	+ cycle < 91 ? 0.5227929675589138 :
	+ cycle < 92 ? 1.202777526370013 :
	+ cycle < 93 ? 0.8873614780109116 :
	+ cycle < 94 ? 1.2123344402548337 :
	+ cycle < 95 ? 0.9530592607296061 :
	+ cycle < 96 ? 0.8610148639466833 :
	+ cycle < 97 ? 0.654047194332189 :
	+ cycle < 98 ? 1.2103972063890933 :
	+ cycle < 99 ? 0.5437779103206848 :
	+ cycle < 100 ? 0.9816240313057238 :
	+ cycle < 101 ? 1.2977240501205123 :
	+ cycle < 102 ? 0.2752299563637399 :
	+ cycle < 103 ? 1.0108428280325816 :
	+ cycle < 104 ? 0.700721101065786 :
	+ cycle < 105 ? 0.13737588331560668 :
	+ cycle < 106 ? 1.0247857781793792 :
	+ cycle < 107 ? 1.2203720359845251 :
	+ cycle < 108 ? 0.5794569518160484 :
	+ cycle < 109 ? 0.8258333105433098 :
	+ cycle < 110 ? 1.3100346274279917 :
	+ cycle < 111 ? 0.6157689678384743 :
	+ cycle < 112 ? 0.6089913240795877 :
	+ cycle < 113 ? 0.7011222289068484 :
	+ cycle < 114 ? 0.8978185908734793 :
	+ cycle < 115 ? 1.168665764198095 :
	+ cycle < 116 ? 0.608363101555297 :
	+ cycle < 117 ? 0.9290543623017008 :
	+ cycle < 118 ? 1.8177181792331698 :
	+ cycle < 119 ? 0.589983024444003 :
	+ cycle < 1;
}

real cycle_dependent_ron_n_2( real cycle ) {
	return
	+ cycle < 0 ? 0.45277019212456626 :
	+ cycle < 1 ? 0.85984522279772 :
	+ cycle < 2 ? 1.6302221413313411 :
	+ cycle < 3 ? 0.5902336787254513 :
	+ cycle < 4 ? 0.6203343821685273 :
	+ cycle < 5 ? 0.8069765424509525 :
	+ cycle < 6 ? 0.5753246545199588 :
	+ cycle < 7 ? 1.327094443938568 :
	+ cycle < 8 ? 0.9536903041746035 :
	+ cycle < 9 ? 0.9452344742158785 :
	+ cycle < 10 ? 0.9634518352698836 :
	+ cycle < 11 ? 0.7652659295300236 :
	+ cycle < 12 ? 1.2905995334522529 :
	+ cycle < 13 ? 1.3064985634553579 :
	+ cycle < 14 ? 1.1878214378701646 :
	+ cycle < 15 ? 0.7406513612840255 :
	+ cycle < 16 ? 0.16062539190914749 :
	+ cycle < 17 ? 1.0167850474729005 :
	+ cycle < 18 ? 1.0847981906647015 :
	+ cycle < 19 ? 0.5043833249500631 :
	+ cycle < 20 ? 0.8747957025800668 :
	+ cycle < 21 ? -0.1935634760939886 :
	+ cycle < 22 ? 1.129846887851205 :
	+ cycle < 23 ? 1.6480432191724526 :
	+ cycle < 24 ? 1.3211171973039186 :
	+ cycle < 25 ? 1.4802924978949146 :
	+ cycle < 26 ? 0.26505550085208973 :
	+ cycle < 27 ? 1.144962814303037 :
	+ cycle < 28 ? 1.2951243963473604 :
	+ cycle < 29 ? 1.1094373971005655 :
	+ cycle < 30 ? 1.148569115491363 :
	+ cycle < 31 ? 0.8793201664344913 :
	+ cycle < 32 ? 0.6859345300396059 :
	+ cycle < 33 ? 1.332474657824978 :
	+ cycle < 34 ? 0.6113385835417067 :
	+ cycle < 35 ? 0.8503063758044652 :
	+ cycle < 36 ? 1.0715348264596702 :
	+ cycle < 37 ? 1.297782872738654 :
	+ cycle < 38 ? 1.0393250182258988 :
	+ cycle < 39 ? 1.0620123279568934 :
	+ cycle < 40 ? 1.6337747540830665 :
	+ cycle < 41 ? 0.9033028709575595 :
	+ cycle < 42 ? 0.6297415549188037 :
	+ cycle < 43 ? 0.2091380428620161 :
	+ cycle < 44 ? 1.2338992674194293 :
	+ cycle < 45 ? 1.5075575099577843 :
	+ cycle < 46 ? 1.1330376918600653 :
	+ cycle < 47 ? 1.4643006514790122 :
	+ cycle < 48 ? 1.3345237106679313 :
	+ cycle < 49 ? 1.362394167608528 :
	+ cycle < 50 ? 1.0514460415732225 :
	+ cycle < 51 ? 0.9191187173400406 :
	+ cycle < 52 ? 0.9489242190395389 :
	+ cycle < 53 ? 1.1152899076425489 :
	+ cycle < 54 ? 1.3345840899653436 :
	+ cycle < 55 ? 0.9897097077732027 :
	+ cycle < 56 ? 1.038675846718166 :
	+ cycle < 57 ? 1.4702735889249012 :
	+ cycle < 58 ? 1.1774544882655729 :
	+ cycle < 59 ? 0.6727421133944632 :
	+ cycle < 60 ? 0.33159782809315064 :
	+ cycle < 61 ? 1.494731798666314 :
	+ cycle < 62 ? 0.16181535982234108 :
	+ cycle < 63 ? 1.3553987898958526 :
	+ cycle < 64 ? 1.1255925667577045 :
	+ cycle < 65 ? 0.9698472409619034 :
	+ cycle < 66 ? 1.1188836371542088 :
	+ cycle < 67 ? 0.8587865970082188 :
	+ cycle < 68 ? 1.3193119626321237 :
	+ cycle < 69 ? 1.0548723748158473 :
	+ cycle < 70 ? 0.20913007858080468 :
	+ cycle < 71 ? 1.1490619612736945 :
	+ cycle < 72 ? 0.8021517496079787 :
	+ cycle < 73 ? 0.7063010798553452 :
	+ cycle < 74 ? 0.7152244983476181 :
	+ cycle < 75 ? 0.9621071463887803 :
	+ cycle < 76 ? 1.2076142315289524 :
	+ cycle < 77 ? 0.5635224726533754 :
	+ cycle < 78 ? 2.081956750421117 :
	+ cycle < 79 ? 1.1263842474875387 :
	+ cycle < 80 ? 0.8766640507580927 :
	+ cycle < 81 ? 0.9558090589228279 :
	+ cycle < 82 ? 0.7605956739537585 :
	+ cycle < 83 ? 0.9830843946550953 :
	+ cycle < 84 ? 1.4313024813718314 :
	+ cycle < 85 ? 0.9521082939590918 :
	+ cycle < 86 ? 1.0780941673161049 :
	+ cycle < 87 ? 0.7256724269383259 :
	+ cycle < 88 ? 1.5033089833600726 :
	+ cycle < 89 ? 1.1161320167411857 :
	+ cycle < 90 ? 1.3448177004740935 :
	+ cycle < 91 ? 0.5494321046526942 :
	+ cycle < 92 ? 0.9341468535042298 :
	+ cycle < 93 ? -0.05480135266072694 :
	+ cycle < 94 ? 0.9412760830836701 :
	+ cycle < 95 ? 0.5216249832933775 :
	+ cycle < 96 ? 0.21356289677027007 :
	+ cycle < 97 ? 1.7040357704669193 :
	+ cycle < 98 ? 0.9667161691329037 :
	+ cycle < 99 ? 1.0844886744942017 :
	+ cycle < 100 ? 0.7225243460992087 :
	+ cycle < 101 ? 1.2365946139166593 :
	+ cycle < 102 ? 0.041885543581353324 :
	+ cycle < 103 ? 0.12112993063017108 :
	+ cycle < 104 ? 0.23349584420938152 :
	+ cycle < 105 ? 1.383044923802995 :
	+ cycle < 106 ? 0.7098997367562085 :
	+ cycle < 107 ? 0.18770926370179575 :
	+ cycle < 108 ? 0.6094981542525969 :
	+ cycle < 109 ? 1.1204817340917224 :
	+ cycle < 110 ? 0.8060539700954047 :
	+ cycle < 111 ? 0.15833317468840624 :
	+ cycle < 112 ? 1.2955189034176444 :
	+ cycle < 113 ? 1.2933226485533265 :
	+ cycle < 114 ? 1.073860970452147 :
	+ cycle < 115 ? 0.7827989194942323 :
	+ cycle < 116 ? 1.0024930487557582 :
	+ cycle < 117 ? 0.9852511980098195 :
	+ cycle < 118 ? 1.4084629184687973 :
	+ cycle < 119 ? 0.9134874567281451 :
	+ cycle < 1;
}

real cycle_dependent_scl_p_2( real cycle ) {
	return
	+ cycle < 0 ? 4.814203596079055 :
	+ cycle < 1 ? 5.802819486225378 :
	+ cycle < 2 ? 6.288081859313108 :
	+ cycle < 3 ? 4.558768547628185 :
	+ cycle < 4 ? 6.392655977409523 :
	+ cycle < 5 ? 4.951598673810991 :
	+ cycle < 6 ? 5.200285988962356 :
	+ cycle < 7 ? 6.770248638385219 :
	+ cycle < 8 ? 4.70105765936479 :
	+ cycle < 9 ? 5.153825706320934 :
	+ cycle < 10 ? 3.8041010931946726 :
	+ cycle < 11 ? 5.6905660163459135 :
	+ cycle < 12 ? 4.565862748788925 :
	+ cycle < 13 ? 7.313590834265075 :
	+ cycle < 14 ? 3.687684216442685 :
	+ cycle < 15 ? 6.25793475577977 :
	+ cycle < 16 ? 4.558867211208955 :
	+ cycle < 17 ? 4.2757879726600825 :
	+ cycle < 18 ? 4.537543351581092 :
	+ cycle < 19 ? 4.323337429175301 :
	+ cycle < 20 ? 3.8213171549973124 :
	+ cycle < 21 ? 6.662122158849201 :
	+ cycle < 22 ? 4.761922778307951 :
	+ cycle < 23 ? 5.98154515722941 :
	+ cycle < 24 ? 4.472055407449828 :
	+ cycle < 25 ? 5.928573008053512 :
	+ cycle < 26 ? 3.881020152941968 :
	+ cycle < 27 ? 5.243318853117474 :
	+ cycle < 28 ? 4.7695078916439275 :
	+ cycle < 29 ? 6.211667629877398 :
	+ cycle < 30 ? 3.754120144910929 :
	+ cycle < 31 ? 4.128789387780036 :
	+ cycle < 32 ? 4.982469968780322 :
	+ cycle < 33 ? 4.119477915219686 :
	+ cycle < 34 ? 3.391142935625536 :
	+ cycle < 35 ? 4.980996800666325 :
	+ cycle < 36 ? 5.222175231413731 :
	+ cycle < 37 ? 5.186411266879119 :
	+ cycle < 38 ? 5.280750432674221 :
	+ cycle < 39 ? 4.025674379160518 :
	+ cycle < 40 ? 4.1090973842803935 :
	+ cycle < 41 ? 2.4738186457666735 :
	+ cycle < 42 ? 4.522540455954267 :
	+ cycle < 43 ? 5.035308127702241 :
	+ cycle < 44 ? 4.341623230129183 :
	+ cycle < 45 ? 3.692419457460389 :
	+ cycle < 46 ? 6.284610980218869 :
	+ cycle < 47 ? 5.406092721968965 :
	+ cycle < 48 ? 6.457675507812765 :
	+ cycle < 49 ? 6.882447507978782 :
	+ cycle < 50 ? 6.201606351039054 :
	+ cycle < 51 ? 4.3622864614486785 :
	+ cycle < 52 ? 3.7311093444028427 :
	+ cycle < 53 ? 4.020651948502881 :
	+ cycle < 54 ? 5.878705491851006 :
	+ cycle < 55 ? 6.6473084544153656 :
	+ cycle < 56 ? 4.328670665523093 :
	+ cycle < 57 ? 3.85022374558059 :
	+ cycle < 58 ? 4.894780802766837 :
	+ cycle < 59 ? 5.045826486083935 :
	+ cycle < 60 ? 4.94336153853472 :
	+ cycle < 61 ? 5.576975046912533 :
	+ cycle < 62 ? 6.0839731279865505 :
	+ cycle < 63 ? 5.701951784396381 :
	+ cycle < 64 ? 4.619236049649809 :
	+ cycle < 65 ? 3.7266993035317393 :
	+ cycle < 66 ? 3.910518053421748 :
	+ cycle < 67 ? 4.404403503610306 :
	+ cycle < 68 ? 5.341828397386768 :
	+ cycle < 69 ? 3.7650957207687723 :
	+ cycle < 70 ? 3.636289059674769 :
	+ cycle < 71 ? 6.452310686785445 :
	+ cycle < 72 ? 4.152246845287928 :
	+ cycle < 73 ? 5.434031892385128 :
	+ cycle < 74 ? 5.52264859970079 :
	+ cycle < 75 ? 5.774579105438423 :
	+ cycle < 76 ? 6.8123326278909 :
	+ cycle < 77 ? 4.162232259885012 :
	+ cycle < 78 ? 3.7052782467294465 :
	+ cycle < 79 ? 4.495050996025377 :
	+ cycle < 80 ? 6.257640174663312 :
	+ cycle < 81 ? 4.132225097695613 :
	+ cycle < 82 ? 5.755095633768109 :
	+ cycle < 83 ? 4.70111318483912 :
	+ cycle < 84 ? 5.1395971935213245 :
	+ cycle < 85 ? 1.7651357766889264 :
	+ cycle < 86 ? 5.516368706279289 :
	+ cycle < 87 ? 3.19727925932727 :
	+ cycle < 88 ? 4.757965947902408 :
	+ cycle < 89 ? 5.329630378616304 :
	+ cycle < 90 ? 5.166196808665405 :
	+ cycle < 91 ? 4.448452397543376 :
	+ cycle < 92 ? 6.010383969461374 :
	+ cycle < 93 ? 4.750701930502704 :
	+ cycle < 94 ? 3.8142237686545206 :
	+ cycle < 95 ? 5.084405046844817 :
	+ cycle < 96 ? 5.862632353888829 :
	+ cycle < 97 ? 5.8231407790088925 :
	+ cycle < 98 ? 6.476122640220987 :
	+ cycle < 99 ? 6.261581784872205 :
	+ cycle < 100 ? 5.3719575894743805 :
	+ cycle < 101 ? 5.34771906672343 :
	+ cycle < 102 ? 5.002756434541384 :
	+ cycle < 103 ? 6.394525795243054 :
	+ cycle < 104 ? 4.353824035508916 :
	+ cycle < 105 ? 4.962438885080813 :
	+ cycle < 106 ? 5.082190246117494 :
	+ cycle < 107 ? 3.960064458221381 :
	+ cycle < 108 ? 5.812514459600293 :
	+ cycle < 109 ? 5.510886541479963 :
	+ cycle < 110 ? 4.500675278741313 :
	+ cycle < 111 ? 4.472587576440301 :
	+ cycle < 112 ? 5.096280104482224 :
	+ cycle < 113 ? 4.642160948545575 :
	+ cycle < 114 ? 4.142479853072333 :
	+ cycle < 115 ? 4.530271713143382 :
	+ cycle < 116 ? 4.206521939075671 :
	+ cycle < 117 ? 5.867568401424519 :
	+ cycle < 118 ? 4.185796037937488 :
	+ cycle < 119 ? 4.334033099579679 :
	+ cycle < 5;
}

real cycle_dependent_scl_n_2( real cycle ) {
	return
	+ cycle < 0 ? 6.131173532052498 :
	+ cycle < 1 ? 9.192706938880882 :
	+ cycle < 2 ? 7.434204960894636 :
	+ cycle < 3 ? 7.568366464247485 :
	+ cycle < 4 ? 6.9955923410829985 :
	+ cycle < 5 ? 7.131003461106358 :
	+ cycle < 6 ? 6.853650302965467 :
	+ cycle < 7 ? 8.025890905843413 :
	+ cycle < 8 ? 6.453079603578565 :
	+ cycle < 9 ? 6.168234044850463 :
	+ cycle < 10 ? 8.210673673435242 :
	+ cycle < 11 ? 9.402612116289538 :
	+ cycle < 12 ? 6.615833107414091 :
	+ cycle < 13 ? 7.074437965423149 :
	+ cycle < 14 ? 7.184132115893745 :
	+ cycle < 15 ? 9.065581788203975 :
	+ cycle < 16 ? 6.297911327351596 :
	+ cycle < 17 ? 6.800812415239621 :
	+ cycle < 18 ? 4.381952970044377 :
	+ cycle < 19 ? 7.971102875116883 :
	+ cycle < 20 ? 7.012847882180693 :
	+ cycle < 21 ? 7.721596309165359 :
	+ cycle < 22 ? 8.084823455300324 :
	+ cycle < 23 ? 7.024500097066975 :
	+ cycle < 24 ? 9.287198223792647 :
	+ cycle < 25 ? 7.956951076846311 :
	+ cycle < 26 ? 4.602168654018325 :
	+ cycle < 27 ? 8.140726596563518 :
	+ cycle < 28 ? 6.41650409162452 :
	+ cycle < 29 ? 6.75471617626099 :
	+ cycle < 30 ? 5.499209474188232 :
	+ cycle < 31 ? 6.206091972676387 :
	+ cycle < 32 ? 7.789305455216118 :
	+ cycle < 33 ? 5.026186624545502 :
	+ cycle < 34 ? 7.512631709487784 :
	+ cycle < 35 ? 5.3796003059154005 :
	+ cycle < 36 ? 5.481507308608314 :
	+ cycle < 37 ? 7.957216190272867 :
	+ cycle < 38 ? 6.210156256108158 :
	+ cycle < 39 ? 6.540524364393307 :
	+ cycle < 40 ? 5.113343253007288 :
	+ cycle < 41 ? 7.662242348819505 :
	+ cycle < 42 ? 7.584828878513045 :
	+ cycle < 43 ? 6.717415357346542 :
	+ cycle < 44 ? 8.273705862841561 :
	+ cycle < 45 ? 6.2153357545438075 :
	+ cycle < 46 ? 6.831189067006386 :
	+ cycle < 47 ? 7.894596475658179 :
	+ cycle < 48 ? 7.1467390553353605 :
	+ cycle < 49 ? 6.733676391239171 :
	+ cycle < 50 ? 7.360020073816676 :
	+ cycle < 51 ? 6.139784411477367 :
	+ cycle < 52 ? 8.059621712542622 :
	+ cycle < 53 ? 6.934780655798141 :
	+ cycle < 54 ? 7.082867239237609 :
	+ cycle < 55 ? 6.271758490711279 :
	+ cycle < 56 ? 6.792982789202825 :
	+ cycle < 57 ? 6.184888383900311 :
	+ cycle < 58 ? 6.827103927194811 :
	+ cycle < 59 ? 6.53206173383926 :
	+ cycle < 60 ? 7.176585191860087 :
	+ cycle < 61 ? 6.917993524059364 :
	+ cycle < 62 ? 6.288442036889805 :
	+ cycle < 63 ? 5.174791583548245 :
	+ cycle < 64 ? 8.566765730512428 :
	+ cycle < 65 ? 6.695263616660997 :
	+ cycle < 66 ? 7.6486536439805075 :
	+ cycle < 67 ? 9.238133282154335 :
	+ cycle < 68 ? 8.309240517740676 :
	+ cycle < 69 ? 5.811771848561528 :
	+ cycle < 70 ? 5.725425593289061 :
	+ cycle < 71 ? 6.46210884990438 :
	+ cycle < 72 ? 6.794684351749211 :
	+ cycle < 73 ? 6.567908659384063 :
	+ cycle < 74 ? 6.582959879737541 :
	+ cycle < 75 ? 5.300870009562677 :
	+ cycle < 76 ? 8.163660174327408 :
	+ cycle < 77 ? 6.54501713999923 :
	+ cycle < 78 ? 8.153889040076663 :
	+ cycle < 79 ? 5.110968177428345 :
	+ cycle < 80 ? 7.411954584729384 :
	+ cycle < 81 ? 6.066151874954956 :
	+ cycle < 82 ? 6.009644808633299 :
	+ cycle < 83 ? 7.850976175350344 :
	+ cycle < 84 ? 7.730911394032565 :
	+ cycle < 85 ? 7.342568258907388 :
	+ cycle < 86 ? 6.104516391692664 :
	+ cycle < 87 ? 7.563914338587433 :
	+ cycle < 88 ? 7.7806191865791625 :
	+ cycle < 89 ? 8.25262434117778 :
	+ cycle < 90 ? 6.980249100422027 :
	+ cycle < 91 ? 7.941302088872671 :
	+ cycle < 92 ? 6.771338395559899 :
	+ cycle < 93 ? 5.605642655978087 :
	+ cycle < 94 ? 8.782913969329922 :
	+ cycle < 95 ? 8.373615438399153 :
	+ cycle < 96 ? 5.963238397485776 :
	+ cycle < 97 ? 8.793010797298603 :
	+ cycle < 98 ? 7.915019777513029 :
	+ cycle < 99 ? 6.686796106668971 :
	+ cycle < 100 ? 8.783533438597864 :
	+ cycle < 101 ? 6.987646833415442 :
	+ cycle < 102 ? 5.543067647285968 :
	+ cycle < 103 ? 6.487966935329679 :
	+ cycle < 104 ? 9.194921099294039 :
	+ cycle < 105 ? 6.260735568888442 :
	+ cycle < 106 ? 3.5916530923186585 :
	+ cycle < 107 ? 6.57362058431713 :
	+ cycle < 108 ? 9.568060709151199 :
	+ cycle < 109 ? 8.343457797153388 :
	+ cycle < 110 ? 4.7364858484016565 :
	+ cycle < 111 ? 8.621813850927422 :
	+ cycle < 112 ? 4.217253310749596 :
	+ cycle < 113 ? 7.86290964839192 :
	+ cycle < 114 ? 7.267145287011549 :
	+ cycle < 115 ? 9.580545347437036 :
	+ cycle < 116 ? 8.437865323485534 :
	+ cycle < 117 ? 3.9844319892792353 :
	+ cycle < 118 ? 8.713039321791824 :
	+ cycle < 119 ? 5.657860050814824 :
	+ cycle < 7;
}
